m1 net1 net1 vdd! vdd pmos
m2 net2 net1 vdd! vdd pmos
m3 ibias ibias gnd! gnd! nmos
m4 net1 ibias gnd! gnd! nmos
m5 net4 ibias gnd! gnd! nmos
m6 net5 in1 net4 gnd! nmos
m7 net6 in2 net4 gnd! nmos
m8 net5 net5 vdd! vdd! pmos
m9 net6 net6 vdd! vdd! pmos
m10 out1 net5 vdd! vdd! pmos
m11 out2 net6 vdd! vdd! pmos
m12 out1 net2 net7 gnd! nmos
m13 out2 net2 net8 gnd! nmos
m14 net7 net9 gnd! gnd! nmos
m15 net8 net9 gnd! gnd! nmos
m16 net9 net9 gnd! gnd! nmos
m17 net9 net1 vdd! vdd! pmos
m18 net10 net1 vdd! vdd! pmos
m19 net13 net1 vdd! vdd! pmos
m20 net11 out2 net10 vdd! pmos
m21 net9 vcm net10 vdd! pmos
m22 net9 vcm net13 vdd! pmos
m23 net11 out1 net13 vdd! pmos
m24 net9 net11 gnd! gnd! nmos
m25 net11 net11 gnd! gnd! nmos
m26 net2 net2 gnd! gnd! nmos

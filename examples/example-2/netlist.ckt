m1 net1 ibias vdd! vdd! pmos
m2 net3 ibias vdd! vdd! pmos
m3 net5 ibias vdd! vdd! pmos
m4 net10 net12 vdd! vdd! pmos
m5 net6 net8 vdd! vdd! pmos
m6 net8 net8 vdd! vdd! pmos
m7 net8 net8 vdd! vdd! pmos
m8 net12 net12 vdd! vdd! pmos
m9 net11 net12 vdd! vdd! pmos
m10 ibias ibias net1 vdd! pmos
m11 net2 ibias net3 vdd! pmos
m12 net4 ibias net5 vdd! pmos
m13 net9 ibias net10 vdd! pmos
m14 output_n ibias net6 vdd! pmos
m15 net7 ibias net8 vdd! pmos
m16 output_p ibias net11 vdd! pmos
m17 net8 in1 net13 gnd! nmos
m18 net12 in2 net13 gnd! nmos
m19 net2 net2 gnd! gnd! nmos
m20 net13 net2 gnd! gnd! nmos
m21 net4 net4 net14 gnd! nmos
m22 net9 net4 net17 gnd! nmos
m23 output_n net4 net15 gnd! nmos
m24 net7 net4 net16 gnd! nmos
m25 output_p net4 net18 gnd! nmos
m26 net14 net14 gnd! gnd! nmos
m27 net17 net17 gnd! gnd! nmos
m28 net15 net17 gnd! gnd! nmos
m29 net16 net16 gnd! gnd! nmos
m30 net18 net16 gnd! gnd! nmos
